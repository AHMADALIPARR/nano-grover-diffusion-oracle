* Simple NMOS inverter (Level-1 style)
* License-ID: SL-AGPL3-001

Vdd vdd 0 DC 1.8
Vin in 0 PULSE(0 1.8 0 1n 1n 50n 100n)
M1 out in 0 0 NMOS W=1u L=0.18u
Rload vdd out 10k
.model NMOS NMOS (LEVEL=1 VTO=0.5 KP=50u)
.tran 0.1n 200n
.end
