* Series RLC — underdamped reference
* License-ID: SL-AGPL3-001

V1 in 0 DC 0 AC 1
R1 in n1 10
L1 n1 n2 1m
C1 n2 0 1u
.ac dec 10 100 1Meg
.tran 1u 5m
.end
