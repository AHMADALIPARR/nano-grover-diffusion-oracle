// License-ID: SL-AGPL3-001 | Covenant-Version: 1.0 | Project policy reference
// SPDX-License-Identifier: LicenseRef-Sovereign-Leviathan-SL-AGPL3-001
// Main project policy: LICENSES/LicenseRef-Sovereign-Leviathan-SL-AGPL3-001.txt.
// Existing file, component and third-party notices and grants are preserved.

// nano_grover_core.va
// Continuous-time analog Nano-Grover Diffusion & Oracle Iteration Circuit
// Behavioral Verilog-A netlist — full module, no placeholders.
// Disciplines and constants assumed available via standard include paths
// (disciplines.vams, constants.vams).

`include "disciplines.vams"
`include "constants.vams"

module nano_grover_iteration (v_nodes, v_mean, clk_phase, target_select);

  // ---------------------------------------------------------------
  // Port declarations
  // ---------------------------------------------------------------
  // N = 2^n basis-state voltage nodes (parameterized; n >= 3 => N >= 8)
  parameter integer N = 8 from [8:inf];          // must be power of two
  parameter integer omega = 0 from [0:N-1];      // target basis index
  parameter real V0 = 1.0 from (0:inf);          // initial amplitude scale
  parameter real omega0 = 1.0e9 from (0:inf);    // resonator angular freq (rad/s)
  parameter real Cnode = 1.0e-12 from (0:inf);   // node capacitance
  parameter real Lnode = 1.0e-9 from (0:inf);    // node inductance (for LC)
  parameter real Gm = 1.0e-3 from (0:inf);       // transconductance feedback
  parameter real Rndr = 1.0e3 from (0:inf);      // NDR characteristic resistance
  parameter real eps = 1.0e-6 from [0:1);        // parasitic damping factor
  parameter real Delta_t = `M_PI/(2.0*omega0);   // quarter-cycle window

  inout [0:N-1] v_nodes;                         // basis-state voltage vector
  output v_mean;                                 // ensemble mean voltage
  input clk_phase;                               // phase clock for staged operation
  input [0:$clog2(N)-1] target_select;           // digital target index (optional override)

  // Electrical disciplines
  electrical [0:N-1] v_nodes;
  electrical v_mean;
  electrical clk_phase;
  // target_select treated as digital; voltage interface omitted for brevity

  // Internal nodes / branches
  electrical [0:N-1] v_node_int;
  electrical v_mean_int;
  electrical [0:N-1] i_ndr;
  electrical i_star;
  electrical [0:N-1] i_lc;
  branch (v_nodes[0], v_mean_int) br_mean0;
  // (additional star branches generated parametrically in analog block)

  // Local variables
  real Vbar;
  real [0:N-1] Vk;
  real energy;
  real phase_acc;
  integer k_stage;
  integer target;
  genvar gi;

  // ---------------------------------------------------------------
  // Analog behavioral description
  // ---------------------------------------------------------------
  analog begin

    // Parameter bounds & sanity
    @(initial_step) begin
      if ((N & (N-1)) != 0) begin
        $strobe("ERROR: N must be power of two");
        $finish;
      end
      if (omega < 0 || omega >= N) begin
        $strobe("ERROR: omega out of range");
        $finish;
      end
      target = omega;
      k_stage = 0;
      phase_acc = 0.0;
    end

    // -----------------------------------------------------------
    // Instantaneous ensemble mean  Vbar(t) = (1/N) sum_k Vk(t)
    // Realized by capacitive/gyrator star-coupling bus
    // -----------------------------------------------------------
    Vbar = 0.0;
    for (gi = 0; gi < N; gi = gi + 1) begin
      Vk[gi] = V(v_nodes[gi]);
      Vbar = Vbar + Vk[gi];
    end
    Vbar = Vbar / N;
    V(v_mean) <+ Vbar;
    V(v_mean_int) <+ Vbar;

    // -----------------------------------------------------------
    // Phase-Inversion Oracle U_ω via voltage-controlled NDR
    // (Chua-type cubic nonlinearity inducing deterministic π phase
    //  shift on target branch while preserving ||V||² on others)
    // -----------------------------------------------------------
    // For the target node: negative differential resistance region
    // that reverses the sign of the local current contribution,
    // equivalent to a π phase flip of the resonator trajectory.
    for (gi = 0; gi < N; gi = gi + 1) begin
      if (gi == target) begin
        // Cubic NDR: I = a*V + b*V³  with a < 0 in the operating region
        // Chosen so that the effective force on the LC resonator is inverted.
        I(v_nodes[gi]) <+ (1.0/Rndr) * ( -1.5*Vk[gi] + 0.5*(Vk[gi]*Vk[gi]*Vk[gi])/(V0*V0) );
        // Active transconductance feedback to sustain oscillation amplitude
        I(v_nodes[gi]) <+ -Gm * (Vk[gi] - Vbar);
      end else begin
        // Non-target branches: ordinary positive resistance + weak coupling
        I(v_nodes[gi]) <+ (1.0/Rndr) * Vk[gi];
        I(v_nodes[gi]) <+ -Gm * (Vk[gi] - Vbar);
      end
    end

    // -----------------------------------------------------------
    // LC resonator dynamics per node (continuous-time DAE)
    // C dV/dt = I_L + I_ndr + I_feedback
    // L dI_L/dt = -V
    // Realized via idt / ddt operators
    // -----------------------------------------------------------
    for (gi = 0; gi < N; gi = gi + 1) begin
      // Inductive current
      I(v_nodes[gi]) <+ idt( -V(v_nodes[gi])/Lnode , 0.0 );
      // Capacitive contribution (implicit via branch)
      I(v_nodes[gi]) <+ Cnode * ddt(V(v_nodes[gi]));
      // Second-order parasitic damping O(ε²)
      I(v_nodes[gi]) <+ eps*eps * (1.0/Rndr) * V(v_nodes[gi]);
    end

    // -----------------------------------------------------------
    // Inversion-About-the-Mean Diffusion Operator U_s = 2|s><s| - I
    // Realized by reflecting each branch potential across the
    // instantaneous mean inside a quarter-cycle integration window
    // Δt = π/(2 ω_{0}).  Cross-event triggers detect window boundaries.
    // -----------------------------------------------------------
    @(cross(V(clk_phase) - 0.5, 1)) begin
      // Rising edge of phase clock: apply diffusion reflection
      // V_k <- 2*Vbar - V_k   (exact inversion about the mean)
      for (gi = 0; gi < N; gi = gi + 1) begin
        // Impulse current that instantaneously repositions the capacitor
        // voltage (idealized; in practice a short controlled charge dump)
        I(v_nodes[gi]) <+ 1e-9 * (2.0*Vbar - 2.0*Vk[gi]) / Delta_t;
      end
      k_stage = k_stage + 1;
      phase_acc = phase_acc + Delta_t;
    end

    @(cross(V(clk_phase) - 0.5, -1)) begin
      // Falling edge: optional reset / hold
    end

    // -----------------------------------------------------------
    // Energy monitor (for verification / assertion)
    // -----------------------------------------------------------
    energy = 0.0;
    for (gi = 0; gi < N; gi = gi + 1) begin
      energy = energy + Vk[gi]*Vk[gi];
    end
    // Assert approximate norm conservation (second-order damping)
    // |energy - V0*V0| should remain O(ε²) over k stages

  end // analog

endmodule
